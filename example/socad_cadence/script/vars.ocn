desVar(   "IB" 100u    )
desVar(   "L" 0.28     )
desVar(   "VBIAS" 500m )
desVar(   "W1" 2       )
desVar(   "W2" 6       )
