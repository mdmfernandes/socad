run()   ; run a simulation

; Output file
out_file = getShellEnvVar("SOCAD_RESULT_FILE")
outf = outfile(out_file "w")

; Simulation results
GAIN = ymax(mag(v("/out" ?result "ac")))
REG1 = pv("M1.m1" "region" ?result "dcOpInfo")
REG2 = pv("M2.m1" "region" ?result "dcOpInfo")
GBW = (gainBwProd(mag(v("/out" ?result "ac"))) || 0.0)
POWER = (- pv("V0" "pwr" ?result "dcOpInfo"))

; Save results to file
fprintf( outf "%s\t%g\n", "GAIN", GAIN)
fprintf( outf "%s\t%d\n", "REG1", REG1)
fprintf( outf "%s\t%d\n", "REG2", REG2)
fprintf( outf "%s\t%g\n", "GBW", GBW)
fprintf( outf "%s\t%e\n", "POWER", POWER)

close(outf) ; Close the file
