; Set up the number notation, precision, etc, of the results
setup(?numberNotation 'engineering)

; Simulator and design folders
simulator( 'spectre )
design("CADENCE_WORKSPACE/simulation/COMMON_SOURCE/spectre/schematic/netlist/netlist")
resultsDir("CADENCE_WORKSPACE/simulation/COMMON_SOURCE/spectre/schematic" )
modelFile(
    '("CADENCE_WORKSPACE/nominal/spectre/nominalwrapper.scs" "")
)
definitionFile(
    "models.scs"
)

; Analysis to perform
analysis('ac ?start "10k"  ?stop "1G"  )
analysis('dc ?saveOppoint t  )
envOption(
    'analysisOrder  list("dc" "ac")
)

; Other settings
temp( 27 )
